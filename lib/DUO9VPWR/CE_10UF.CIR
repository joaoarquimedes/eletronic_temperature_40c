* CE Polarized Capacitor
*
* SPICE (Simulation Program with Integrated Circuit Emphasis)
* SUBCIRCUIT
*
* C = Capacitance  (C1)
* ESL = Equivalent Series Inductance (L1)
* IR = Insulation Resistance (R2)
* ESR = Equivalent Series Resistance (R1)
* ELR = Equivalent Inductive Resistance (R3)
*
* Connections:
*                 +
*                 |  -
*                 |  |
.SUBCKT CE_10UF   1  2
L1    1     4     2.5M
R1    4     3     300M
C1    3     2     10U
R2    3     2     1000MEG
R3    1     4     10
.ENDS
