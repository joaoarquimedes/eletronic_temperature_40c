* XFRMCTPCB
*
* SPICE (Simulation Program with Integrated Circuit Emphasis)
* SUBCIRCUIT
*
* Primary Voltage 120/20mA
* Secondary Voltage CT 24/100mA
*
* P1_______      _______S1
*          ) || (
*          ) || (_______CT
*          ) || (
* P2_______) || (_______S2
*
.SUBCKT XFRMCTPCB P1 P2 S1 CT S2
*
L1 6 P2	10
L2 7 CT	0.1
L3 8 S2	0.1
RL1 P1 6 77.45966692
RL2 S1 7 3.464101615
RL3 CT 8 3.464101615
RG1 P2 0 1G
RG2 0 CT 1G
RG3 0 S2 1G
K12 L1 L2 0.999997999994
K13 L1 L3 0.999997999994
K23 L2 L3 0.999997999994
.ENDS
