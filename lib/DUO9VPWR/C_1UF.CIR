* C Non-Polarized Capacitor
*
* SPICE (Simulation Program with Integrated Circuit Emphasis)
* SUBCIRCUIT
*
* C = Capacitance  (C)
* ESL = Equivalent Series Inductance (LS)
* IR = Insulation Resistance (RI)
* ESR = Equivalent Series Resistance (RS)
* ELR = Equivalent Inductive Resistance (RLS)
*
.SUBCKT C_1UF 1 2
LS    1     4     10N
RS    4     3     100M
C1    3     2     1U
RI    3     2     1000MEG
RLS   1     4     10
.ENDS
